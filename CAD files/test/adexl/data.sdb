ADE simulation setup
Run mode: Single Run, Sweeps and Corners
Tests:
  newTr:test:1: newTr/test/schematic, simulator spectre
Global variables:
  C = 1p
  L = 1k
  Tclk = 20n
  Tfall = 100p
  Thigh = 10n
  Trise = 100p
  VDD0 = 1
