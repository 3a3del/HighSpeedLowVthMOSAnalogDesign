ADE simulation setup
Run mode: Single Run, Sweeps and Corners
Tests:
  umc13mmrf:t3:1: umc13mmrf/t3/schematic, simulator spectre
    Outputs: prl
Global variables:
  Iref = {From/To}Linear:30m:5m:40m{From/To}
  L = 340n
  R = {From/To}Linear:24:2:30{From/To}
