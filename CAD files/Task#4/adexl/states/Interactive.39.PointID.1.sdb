ADE simulation setup
Global variables:
  IREF = 10m
  L = 340n
  C = 10
