ADE simulation setup
Run mode: Single Run, Sweeps and Corners
Tests:
  newTr:Task#4:1: newTr/Task#4/schematic, simulator spectre
    Outputs: LINEARITY/ERROR; Efficinecy; PSupply
Global variables:
  IREF = {From/To}Linear:10m:5m:40m{From/To}
  L = 340n
  C = {From/To}Linear:12:2:46{From/To}
